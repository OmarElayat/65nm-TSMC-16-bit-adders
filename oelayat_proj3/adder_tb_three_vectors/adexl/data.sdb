ADE simulation setup
Run mode: Single Run, Sweeps and Corners
Tests:
  oelayat_proj3:adder_tb_three_vectors:1: oelayat_proj3/adder_tb_three_vectors/schematic, simulator spectre
Global variables:
  v = 1.2
  ptl = 1
  buf = 2
  x = 2
Corners:
  model folders: /CMC/kits/tsmc_65nm/CRN65GP/TN65CMSP018K3_V1.0C/models/spectre
  C2: temperature=-25; crn65gplus_2d5_lk_v1d0.scs[ff]
  C4: temperature=27; crn65gplus_2d5_lk_v1d0.scs[tt]
  C3: temperature=85; crn65gplus_2d5_lk_v1d0.scs[ss]
