ADE simulation setup
Run mode: Single Run, Sweeps and Corners
Global variables:
  ptl = 1
  buf = 2
  x = 2
  v = 1.2
Corners (nominal off):
  model folders: /CMC/kits/tsmc_65nm/CRN65GP/TN65CMSP018K3_V1.0C/models/spectre
  C4: temperature=-25; crn65gplus_2d5_lk_v1d0.scs[ff]
  C5: temperature=27; crn65gplus_2d5_lk_v1d0.scs[tt]
  C6: temperature=85; crn65gplus_2d5_lk_v1d0.scs[ss]
